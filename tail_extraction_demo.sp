* ===== FULL HSPICE INTERNAL: MODEL-BASED 6? TAIL EXTRACTION =====

* Idea: sigma? "?? ?? ?"?? ?? ?? ???,
*       model parameter (AVTH0)? ???? HSPICE? ?? ???? ?

* ===== SSG CORNER + LOCAL MISMATCH MODEL =====
.LIB './corners.lib' SSG

* ===== DEVICE DIMENSIONS (pass-gate) =====
.PARAM WPG=160N
.PARAM LCELL=30N

* ===== STEP 1: Model Base?? Sigma(Vth) ?? =====
* Foundry mismatch model:
*   ?(Vth) = AVTH0 / sqrt(W_eff * L_eff)
* AVTH0 ?? .MODEL ??? ???? ??,
* W_eff, L_eff? netlist ????.
* ? ??? HSPICE? ?? ???? sigma ??.

* AVTH0 from model (?: 2mV?um ? 2E-3 V?um)
* ???? PDK .MODEL?? ?? ???:
.PARAM AVTH0_MODEL=2E-3        * V?um, model?? ? ?
.PARAM SIGMA_VTH='AVTH0_MODEL / SQRT(WPG * LCELL)'
* SIGMA_VTH = HSPICE? model parameter? ??? 1?

* ===== STEP 2: ? ?? device?? sigma ?? (MC?) =====
* MC? ??? ? ???? ??? sigma? model??
* ??? ??? ?? ????? ??.
* ?? ?? ??? HSPICE ???? ????.

M_MON D G 0 0 NMOS_SRAM W=WPG L=LCELL
VG G 0 DC=VDD
VD D 0 DC=VDD
.DC VG 0 VDD 0.01
.MEASURE DC VTH_MON I(M_MON) WHEN I(M_MON)=1E-7*WPG/LCELL CROSS=1

* MC 200 runs ? model? ?? ?(Vth) ??
.MC 200 RUN MEASURE VTH_MON
.MEASURE MC SIGMA_VTH_MC STD VTH_MON
* SIGMA_VTH_MC ? SIGMA_VTH (???? model ?? ?? ??)

* ===== STEP 3: ?Vth Sweep?? ?? 6? Tail Iread ?? =====
* ??? ??? ?(Vth)? ??? pass-gate? Vth? ?? sweep.
* ?? ??? ?: linear approximation? ??,
*   model? ???? ???? Iread ?? ??.
*   GIDL, junction leakage saturation? ?? ???.

* Pass-gate with explicit Vth offset
.PARAM NSIG=0
MPG1 BL WL VVDD 0 NMOS_SRAM W=WPG L=LCELL
+ VTH0='VTH0_NOM + NSIG * SIGMA_VTH'
*               ? offset ?? ? tail ???? ??

* Bitcell? nominal SSG ?? ??
MPU1 VVDD VVDD2 VDD VDD PMOS_SRAM W=120N L=30N
MPD1 VVDD VVDD2 0 0 NMOS_SRAM W=200N L=30N
MPG2 BLB WL VVDD2 0 NMOS_SRAM W=160N L=30N
...

* Read condition
WL WL 0 DC=VDD
BL BL 0 DC=VDD
BLB BLB 0 DC=VDD

* ===== CORE: NSIG? DC sweep ??? ?? =====
* 0? (nominal) ? -8? (extreme tail), 0.1? step
.DC NSIG 0 -8 -0.1

* ? step?? HSPICE? real device model? ??? Iread
.MEASURE DC IREAD_CUR I(MPG1)
* ? model parameters + nonlinearity + GIDL ?? ??

* ===== RESULT: 6? Tail = Iread at NSIG = -6 =====
.MEASURE DC IREAD_6SIG FIND I(MPG1) AT NSIG=-6

* ===== ??: ?(VTH) ?? ?? =====
.MEASURE PARAM SIGMA_RATIO PARAM='SIGMA_VTH_MC / SIGMA_VTH'
* 0.9~1.1?? model ?? ?? ??
.END
